* SPICE Simulation: 3-Phase BLDC Motor Inverter (FIXED & VALIDATED)
* Objective: Validate MOSFET switching, current ripple, EMI, thermal profile
* Tool: ngspice compatible
* Motor: 3-Phase PMSM / BLDC (48V / 400V compatible)
* Control: 3-phase complementary PWM with deadtime, 20kHz

.title 3-Phase BLDC Inverter Simulation - Verified

* ============= POWER SUPPLY =============
Vdc vdc gnd DC 48
R_src vdc vdc_filt 0.05
Cbulk vdc_filt gnd 470u

* ============= PWM CONTROL SIGNALS (20 kHz, complementary with dead-time) =============
* Phase U High-Side (0°, 48% duty) and Low-Side (inverted with deadtime)
Vpwm_hs_u gate_hs_u gnd PULSE(0 12 0u 100n 100n 23.5u 50u)
Vpwm_ls_u gate_ls_u gnd PULSE(0 12 25u 100n 100n 23.5u 50u)

* Phase V High-Side (120° = 16.67us) and Low-Side
Vpwm_hs_v gate_hs_v gnd PULSE(0 12 16.67u 100n 100n 23.5u 50u)
Vpwm_ls_v gate_ls_v gnd PULSE(0 12 41.67u 100n 100n 23.5u 50u)

* Phase W High-Side (240° = 33.33us) and Low-Side
Vpwm_hs_w gate_hs_w gnd PULSE(0 12 33.33u 100n 100n 23.5u 50u)
Vpwm_ls_w gate_ls_w gnd PULSE(0 12 8.33u 100n 100n 23.5u 50u)

* ============= 3-PHASE MOSFET BRIDGE =============
* MOSFET switch model (IRFB4110: Ron = 4.5mOhm)
.model sw_mosfet SW(VT=4 VH=1 RON=0.0045 ROFF=1e6)

* Phase U Bridge
Shs_u vdc_filt phase_u gate_hs_u gnd sw_mosfet
Sls_u phase_u gnd gate_ls_u gnd sw_mosfet
Dhs_u phase_u vdc_filt d_body
Dls_u gnd phase_u d_body

* Phase V Bridge
Shs_v vdc_filt phase_v gate_hs_v gnd sw_mosfet
Sls_v phase_v gnd gate_ls_v gnd sw_mosfet
Dhs_v phase_v vdc_filt d_body
Dls_v gnd phase_v d_body

* Phase W Bridge
Shs_w vdc_filt phase_w gate_hs_w gnd sw_mosfet
Sls_w phase_w gnd gate_ls_w gnd sw_mosfet
Dhs_w phase_w vdc_filt d_body
Dls_w gnd phase_w d_body

* Body Diode Model
.model d_body D(IS=1e-9 RS=0.01 BV=100 IBV=1m)

* Snubbers RC (EMI mitigation)
Rsnub_u phase_u csnub_u_node 10
Csnub_u csnub_u_node gnd 1n

Rsnub_v phase_v csnub_v_node 10
Csnub_v csnub_v_node gnd 1n

Rsnub_w phase_w csnub_w_node 10
Csnub_w csnub_w_node gnd 1n

* ============= MOTOR PHASE IMPEDANCES (Y-Connected PMSM) =============
* Phase U
Lphase_u phase_u neutral_u 100u
Rphase_u neutral_u emf_u 0.05
Vbemf_u emf_u neutral SIN(0 20 200 0 0)

* Phase V (120 deg)
Lphase_v phase_v neutral_v 100u
Rphase_v neutral_v emf_v 0.05
Vbemf_v emf_v neutral SIN(0 20 200 1.667m 0)

* Phase W (240 deg)
Lphase_w phase_w neutral_w 100u
Rphase_w neutral_w emf_w 0.05
Vbemf_w emf_w neutral SIN(0 20 200 3.333m 0)

* Neutral point grounding reference
Rneutral neutral gnd 100k

* ============= CURRENT SENSING SHUNTS =============
Rshunt_u phase_u phase_u_sense 0.001
Rshunt_v phase_v phase_v_sense 0.001
Rshunt_w phase_w phase_w_sense 0.001

* ============= TRANSIENT SIMULATION =============
.tran 500n 2m 0 500n
.options reltol=0.005 abstol=1e-6 vntol=1e-4

* ============= MEASUREMENTS =============
.measure tran Vdc_avg AVG V(vdc_filt)
.measure tran Vphase_u_peak MAX V(phase_u)
.measure tran I_u_rms RMS I(Lphase_u)

.end
